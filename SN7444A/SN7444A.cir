.title KiCad schematic
U29 Net-_U29-Pad1_ Net-_U12-Pad2_ Net-_U29-Pad3_ d_and
U28 Net-_U34-Pad1_ Net-_U32-Pad2_ Net-_U28-Pad3_ d_and
U27 Net-_U25-Pad1_ Net-_U12-Pad2_ Net-_U27-Pad3_ d_and
U63 Net-_U53-Pad2_ 7 dac_bridge_1
U42 Net-_U27-Pad3_ Net-_U28-Pad3_ Net-_U42-Pad3_ d_and
U52 Net-_U42-Pad3_ Net-_U52-Pad2_ d_inverter
U62 Net-_U52-Pad2_ 6 dac_bridge_1
U43 Net-_U29-Pad3_ Net-_U30-Pad3_ Net-_U43-Pad3_ d_and
U53 Net-_U43-Pad3_ Net-_U53-Pad2_ d_inverter
U1 Net-_U1-Pad1_ Net-_U32-Pad2_ d_buffer
U73 7 plot_v1
U72 6 plot_v1
U77 Net-_U4-Pad2_ Net-_U1-Pad1_ d_inverter
U5 Net-_U5-Pad1_ Net-_U34-Pad1_ d_buffer
U69 3 plot_v1
U59 Net-_U49-Pad2_ 3 dac_bridge_1
U67 1 plot_v1
U57 Net-_U47-Pad2_ 1 dac_bridge_1
U68 2 plot_v1
U58 Net-_U48-Pad2_ 2 dac_bridge_1
U61 Net-_U51-Pad2_ 5 dac_bridge_1
U70 4 plot_v1
U60 Net-_U50-Pad2_ 4 dac_bridge_1
U71 5 plot_v1
U41 Net-_U25-Pad3_ Net-_U26-Pad3_ Net-_U41-Pad3_ d_and
U51 Net-_U41-Pad3_ Net-_U51-Pad2_ d_inverter
U40 Net-_U23-Pad3_ Net-_U24-Pad3_ Net-_U40-Pad3_ d_and
U39 Net-_U21-Pad3_ Net-_U22-Pad3_ Net-_U39-Pad3_ d_and
U49 Net-_U39-Pad3_ Net-_U49-Pad2_ d_inverter
U50 Net-_U40-Pad3_ Net-_U50-Pad2_ d_inverter
U47 Net-_U37-Pad3_ Net-_U47-Pad2_ d_inverter
U37 Net-_U17-Pad3_ Net-_U18-Pad3_ Net-_U37-Pad3_ d_and
U48 Net-_U38-Pad3_ Net-_U48-Pad2_ d_inverter
U38 Net-_U19-Pad3_ Net-_U20-Pad3_ Net-_U38-Pad3_ d_and
U79 Net-_U12-Pad2_ Net-_U79-Pad2_ d_inverter
U9 Net-_U79-Pad2_ Net-_U9-Pad2_ d_buffer
U13 Net-_U13-Pad1_ Net-_U29-Pad1_ d_buffer
U80 Net-_U25-Pad1_ Net-_U13-Pad1_ d_inverter
U11 14 Net-_U11-Pad2_ adc_bridge_1
U10 14 plot_v1
U15 15 Net-_U15-Pad2_ adc_bridge_1
U14 15 plot_v1
v2 13 GND pulse
v1 12 GND pulse
U6 13 plot_v1
U2 12 plot_v1
U3 12 Net-_U3-Pad2_ adc_bridge_1
U7 13 Net-_U7-Pad2_ adc_bridge_1
v3 14 GND pulse
v4 15 GND pulse
U16 Net-_U15-Pad2_ Net-_U25-Pad1_ d_inverter
U12 Net-_U11-Pad2_ Net-_U12-Pad2_ d_inverter
U8 Net-_U7-Pad2_ Net-_U36-Pad1_ d_inverter
U4 Net-_U3-Pad2_ Net-_U4-Pad2_ d_inverter
U78 Net-_U36-Pad1_ Net-_U5-Pad1_ d_inverter
U26 Net-_U34-Pad1_ Net-_U4-Pad2_ Net-_U26-Pad3_ d_and
U25 Net-_U25-Pad1_ Net-_U12-Pad2_ Net-_U25-Pad3_ d_and
U23 Net-_U29-Pad1_ Net-_U12-Pad2_ Net-_U23-Pad3_ d_and
U24 Net-_U34-Pad1_ Net-_U4-Pad2_ Net-_U24-Pad3_ d_and
U22 Net-_U34-Pad1_ Net-_U4-Pad2_ Net-_U22-Pad3_ d_and
U30 Net-_U34-Pad1_ Net-_U32-Pad2_ Net-_U30-Pad3_ d_and
U32 Net-_U34-Pad1_ Net-_U32-Pad2_ Net-_U32-Pad3_ d_and
U31 Net-_U29-Pad1_ Net-_U9-Pad2_ Net-_U31-Pad3_ d_and
U45 Net-_U33-Pad3_ Net-_U34-Pad3_ Net-_U45-Pad3_ d_and
U44 Net-_U31-Pad3_ Net-_U32-Pad3_ Net-_U44-Pad3_ d_and
U55 Net-_U45-Pad3_ Net-_U55-Pad2_ d_inverter
U54 Net-_U44-Pad3_ Net-_U54-Pad2_ d_inverter
U75 9 plot_v1
U65 Net-_U55-Pad2_ 9 dac_bridge_1
U74 8 plot_v1
U64 Net-_U54-Pad2_ 8 dac_bridge_1
U76 10 plot_v1
U66 Net-_U56-Pad2_ 10 dac_bridge_1
U56 Net-_U46-Pad3_ Net-_U56-Pad2_ d_inverter
U46 Net-_U35-Pad3_ Net-_U36-Pad3_ Net-_U46-Pad3_ d_and
U35 Net-_U25-Pad1_ Net-_U9-Pad2_ Net-_U35-Pad3_ d_and
U34 Net-_U34-Pad1_ Net-_U32-Pad2_ Net-_U34-Pad3_ d_and
U33 Net-_U25-Pad1_ Net-_U9-Pad2_ Net-_U33-Pad3_ d_and
U36 Net-_U36-Pad1_ Net-_U32-Pad2_ Net-_U36-Pad3_ d_and
U21 Net-_U29-Pad1_ Net-_U9-Pad2_ Net-_U21-Pad3_ d_and
U20 Net-_U34-Pad1_ Net-_U4-Pad2_ Net-_U20-Pad3_ d_and
U19 Net-_U25-Pad1_ Net-_U9-Pad2_ Net-_U19-Pad3_ d_and
U18 Net-_U36-Pad1_ Net-_U4-Pad2_ Net-_U18-Pad3_ d_and
U17 Net-_U25-Pad1_ Net-_U9-Pad2_ Net-_U17-Pad3_ d_and
.end
