.title KiCad schematic
U13 2/B2 plot_v1
v5 2/B2 GND pulse
v4 3/A2 GND pulse
v8 12/A4 GND pulse
U24 12/A4 plot_v1
U7 3/A2 Net-_U7-Pad2_ adc_bridge_1
U11 2/B2 Net-_U11-Pad2_ adc_bridge_1
U16 Net-_U14-Pad2_ Net-_U16-Pad2_ d_buffer
U14 14/A3 Net-_U14-Pad2_ adc_bridge_1
U8 Net-_U7-Pad2_ Net-_U30-Pad1_ d_buffer
U12 Net-_U11-Pad2_ Net-_U12-Pad2_ d_buffer
U22 12/A4 Net-_U22-Pad2_ adc_bridge_1
U26 Net-_U25-Pad2_ Net-_U26-Pad2_ d_buffer
U20 Net-_U19-Pad2_ Net-_U20-Pad2_ d_buffer
U23 Net-_U22-Pad2_ Net-_U23-Pad2_ d_buffer
U25 11/B4 Net-_U25-Pad2_ adc_bridge_1
U19 15/B3 Net-_U19-Pad2_ adc_bridge_1
v9 11/B4 GND pulse
U27 11/B4 plot_v1
v6 14/A3 GND pulse
U17 14/A3 plot_v1
U21 15/B3 plot_v1
v7 15/B3 GND pulse
U18 6/B1 plot_v1
U9 5/A1 plot_v1
U6 5/A1 Net-_U6-Pad2_ adc_bridge_1
U3 Net-_U6-Pad2_ Net-_U28-Pad1_ d_buffer
U2 Net-_U1-Pad2_ Net-_U2-Pad2_ d_buffer
U4 Net-_U15-Pad2_ Net-_U28-Pad2_ d_buffer
U1 7/CIN Net-_U1-Pad2_ adc_bridge_1
U15 6/B1 Net-_U15-Pad2_ adc_bridge_1
v2 5/A1 GND pulse
U5 7/CIN plot_v1
v1 7/CIN GND pulse
U10 3/A2 plot_v1
v3 6/B1 GND pulse
U28 Net-_U28-Pad1_ Net-_U28-Pad2_ Net-_U28-Pad3_ d_and
U31 Net-_U30-Pad1_ Net-_U12-Pad2_ Net-_U31-Pad3_ d_xor
U29 Net-_U28-Pad1_ Net-_U28-Pad2_ Net-_U29-Pad3_ d_xor
U30 Net-_U30-Pad1_ Net-_U12-Pad2_ Net-_U30-Pad3_ d_and
U32 Net-_U16-Pad2_ Net-_U20-Pad2_ Net-_U32-Pad3_ d_and
U34 Net-_U23-Pad2_ Net-_U26-Pad2_ Net-_U34-Pad3_ d_and
U33 Net-_U16-Pad2_ Net-_U20-Pad2_ Net-_U33-Pad3_ d_xor
U35 Net-_U23-Pad2_ Net-_U26-Pad2_ Net-_U35-Pad3_ d_xor
U37 Net-_U28-Pad3_ Net-_U31-Pad3_ Net-_U37-Pad3_ d_and
U36 Net-_U29-Pad3_ Net-_U2-Pad2_ Net-_U36-Pad3_ d_and
U38 Net-_U28-Pad3_ Net-_U36-Pad3_ Net-_U38-Pad3_ d_or
U67 Net-_U65-Pad3_ Net-_U67-Pad2_ d_buffer
U68 Net-_U66-Pad3_ Net-_U35-Pad3_ Net-_U68-Pad3_ d_or
U73 Net-_U72-Pad2_ 9/COUT dac_bridge_1
U70 Net-_U68-Pad3_ Net-_U56-Pad3_ Net-_U70-Pad3_ d_or
U69 Net-_U67-Pad2_ 10/S4 dac_bridge_1
U72 Net-_U70-Pad3_ Net-_U72-Pad2_ d_buffer
U71 10/S4 plot_v1
U74 9/COUT plot_v1
U54 Net-_U32-Pad3_ Net-_U35-Pad3_ Net-_U54-Pad3_ d_and
U60 Net-_U48-Pad3_ Net-_U35-Pad3_ Net-_U60-Pad3_ d_and
U56 Net-_U54-Pad3_ Net-_U34-Pad3_ Net-_U56-Pad3_ d_or
U66 Net-_U63-Pad3_ Net-_U60-Pad3_ Net-_U66-Pad3_ d_or
U63 Net-_U59-Pad3_ Net-_U35-Pad3_ Net-_U63-Pad3_ d_and
U59 Net-_U37-Pad3_ Net-_U33-Pad3_ Net-_U59-Pad3_ d_and
U64 13/S3 plot_v1
U61 Net-_U57-Pad2_ 13/S3 dac_bridge_1
U57 Net-_U55-Pad3_ Net-_U57-Pad2_ d_buffer
U58 Net-_U53-Pad3_ Net-_U52-Pad3_ Net-_U58-Pad3_ d_or
U65 Net-_U62-Pad3_ Net-_U35-Pad3_ Net-_U65-Pad3_ d_xor
U62 Net-_U58-Pad3_ Net-_U59-Pad3_ Net-_U62-Pad3_ d_or
U53 Net-_U32-Pad3_ Net-_U48-Pad3_ Net-_U53-Pad3_ d_or
U52 Net-_U30-Pad3_ Net-_U33-Pad3_ Net-_U52-Pad3_ d_and
U48 Net-_U45-Pad3_ Net-_U33-Pad3_ Net-_U48-Pad3_ d_and
U55 Net-_U50-Pad3_ Net-_U33-Pad3_ Net-_U55-Pad3_ d_xor
U39 Net-_U29-Pad3_ Net-_U2-Pad2_ Net-_U39-Pad3_ d_xor
U40 Net-_U29-Pad3_ Net-_U31-Pad3_ Net-_U40-Pad3_ d_and
U43 Net-_U39-Pad3_ Net-_U43-Pad2_ d_buffer
U41 Net-_U31-Pad3_ Net-_U38-Pad3_ Net-_U41-Pad3_ d_xor
U42 Net-_U30-Pad3_ Net-_U37-Pad3_ Net-_U42-Pad3_ d_or
U50 Net-_U45-Pad3_ Net-_U42-Pad3_ Net-_U50-Pad3_ d_or
U49 Net-_U44-Pad2_ 1/S2 dac_bridge_1
U51 1/S2 plot_v1
U46 Net-_U43-Pad2_ 4/S1 dac_bridge_1
U44 Net-_U41-Pad3_ Net-_U44-Pad2_ d_buffer
U47 4/S1 plot_v1
U45 Net-_U40-Pad3_ Net-_U2-Pad2_ Net-_U45-Pad3_ d_and
.end
