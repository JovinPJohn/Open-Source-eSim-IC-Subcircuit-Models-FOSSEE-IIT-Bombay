.title KiCad schematic
U5 Net-_U32-Pad3_ Net-_U29-Pad3_ Net-_U17-Pad1_ d_nor
U29 Net-_U19-Pad2_ Net-_U26-Pad2_ Net-_U29-Pad3_ d_and
U32 Net-_U24-Pad2_ Net-_U25-Pad2_ Net-_U32-Pad3_ d_and
U4 Net-_U27-Pad3_ Net-_U31-Pad3_ Net-_U12-Pad1_ d_nor
U31 Net-_U16-Pad2_ Net-_U23-Pad2_ Net-_U31-Pad3_ d_and
U27 Net-_U14-Pad2_ Net-_U15-Pad2_ Net-_U27-Pad3_ d_and
U18 8_1Y plot_v1
U17 Net-_U17-Pad1_ 6_2Y dac_bridge_1
U20 6_2Y plot_v1
U12 Net-_U12-Pad1_ 8_1Y dac_bridge_1
v3 9_1C GND pulse
v2 13_1B GND pulse
v1 1_1A GND pulse
U2 13_1B plot_v1
U14 1_1A Net-_U14-Pad2_ adc_bridge_1
U1 1_1A plot_v1
U15 13_1B Net-_U15-Pad2_ adc_bridge_1
v6 10_1D GND pulse
U16 9_1C Net-_U16-Pad2_ adc_bridge_1
U3 9_1C plot_v1
U6 10_1D plot_v1
U23 10_1D Net-_U23-Pad2_ adc_bridge_1
v7 2_2A GND pulse
v8 3_2B GND pulse
U8 3_2B plot_v1
U25 3_2B Net-_U25-Pad2_ adc_bridge_1
v13 4_2C GND pulse
v9 5_2D GND pulse
U13 4_2C plot_v1
U19 5_2D Net-_U19-Pad2_ adc_bridge_1
U26 4_2C Net-_U26-Pad2_ adc_bridge_1
U9 5_2D plot_v1
U24 2_2A Net-_U24-Pad2_ adc_bridge_1
U7 2_2A plot_v1
.end
