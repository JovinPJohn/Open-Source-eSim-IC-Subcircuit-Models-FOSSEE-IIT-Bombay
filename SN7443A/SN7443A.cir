.title KiCad schematic
U73 7 plot_v1
U63 Net-_U53-Pad2_ 7 dac_bridge_1
U52 Net-_U42-Pad3_ Net-_U52-Pad2_ d_inverter
U62 Net-_U52-Pad2_ 6 dac_bridge_1
U72 6 plot_v1
U53 Net-_U43-Pad3_ Net-_U53-Pad2_ d_inverter
U46 Net-_U46-Pad1_ Net-_U46-Pad2_ Net-_U46-Pad3_ d_and
U56 Net-_U46-Pad3_ Net-_U56-Pad2_ d_inverter
U42 Net-_U27-Pad3_ Net-_U28-Pad3_ Net-_U42-Pad3_ d_and
U43 Net-_U29-Pad3_ Net-_U30-Pad3_ Net-_U43-Pad3_ d_and
U74 8 plot_v1
U65 Net-_U55-Pad2_ 9 dac_bridge_1
U75 9 plot_v1
U64 Net-_U54-Pad2_ 8 dac_bridge_1
U54 Net-_U44-Pad3_ Net-_U54-Pad2_ d_inverter
U44 Net-_U31-Pad3_ Net-_U32-Pad3_ Net-_U44-Pad3_ d_and
U45 Net-_U33-Pad3_ Net-_U34-Pad3_ Net-_U45-Pad3_ d_and
U55 Net-_U45-Pad3_ Net-_U55-Pad2_ d_inverter
U76 10 plot_v1
U66 Net-_U56-Pad2_ 10 dac_bridge_1
U32 Net-_U28-Pad1_ Net-_U1-Pad2_ Net-_U32-Pad3_ d_and
U36 Net-_U36-Pad1_ Net-_U1-Pad2_ Net-_U46-Pad2_ d_and
U33 Net-_U13-Pad2_ Net-_U23-Pad2_ Net-_U33-Pad3_ d_and
U34 Net-_U28-Pad1_ Net-_U1-Pad2_ Net-_U34-Pad3_ d_and
U35 Net-_U16-Pad2_ Net-_U12-Pad2_ Net-_U46-Pad1_ d_and
U30 Net-_U28-Pad1_ Net-_U1-Pad2_ Net-_U30-Pad3_ d_and
U28 Net-_U28-Pad1_ Net-_U1-Pad2_ Net-_U28-Pad3_ d_and
U29 Net-_U13-Pad2_ Net-_U12-Pad2_ Net-_U29-Pad3_ d_and
U31 Net-_U16-Pad2_ Net-_U23-Pad2_ Net-_U31-Pad3_ d_and
U27 Net-_U16-Pad2_ Net-_U12-Pad2_ Net-_U27-Pad3_ d_and
v1 12 GND pulse
v2 13 GND pulse
U14 15 plot_v1
U10 14 plot_v1
U15 15 Net-_U15-Pad2_ adc_bridge_1
U11 14 Net-_U11-Pad2_ adc_bridge_1
U6 13 plot_v1
U7 13 Net-_U7-Pad2_ adc_bridge_1
v4 15 GND pulse
v3 14 GND pulse
U3 12 Net-_U3-Pad2_ adc_bridge_1
U4 Net-_U3-Pad2_ Net-_U4-Pad2_ d_inverter
U2 12 plot_v1
U12 Net-_U11-Pad2_ Net-_U12-Pad2_ d_inverter
U8 Net-_U7-Pad2_ Net-_U28-Pad1_ d_inverter
U16 Net-_U15-Pad2_ Net-_U16-Pad2_ d_inverter
U13 Net-_U13-Pad1_ Net-_U13-Pad2_ d_buffer
U80 Net-_U16-Pad2_ Net-_U13-Pad1_ d_inverter
U9 Net-_U79-Pad2_ Net-_U23-Pad2_ d_buffer
U79 Net-_U12-Pad2_ Net-_U79-Pad2_ d_inverter
U1 Net-_U1-Pad1_ Net-_U1-Pad2_ d_buffer
U77 Net-_U4-Pad2_ Net-_U1-Pad1_ d_inverter
U78 Net-_U28-Pad1_ Net-_U5-Pad1_ d_inverter
U5 Net-_U5-Pad1_ Net-_U36-Pad1_ d_buffer
U22 Net-_U36-Pad1_ Net-_U4-Pad2_ Net-_U22-Pad3_ d_and
U21 Net-_U13-Pad2_ Net-_U12-Pad2_ Net-_U21-Pad3_ d_and
U23 Net-_U16-Pad2_ Net-_U23-Pad2_ Net-_U40-Pad1_ d_and
U24 Net-_U36-Pad1_ Net-_U4-Pad2_ Net-_U24-Pad3_ d_and
U25 Net-_U13-Pad2_ Net-_U23-Pad2_ Net-_U25-Pad3_ d_and
U26 Net-_U36-Pad1_ Net-_U4-Pad2_ Net-_U41-Pad2_ d_and
U20 Net-_U36-Pad1_ Net-_U4-Pad2_ Net-_U38-Pad2_ d_and
U19 Net-_U16-Pad2_ Net-_U12-Pad2_ Net-_U38-Pad1_ d_and
U17 Net-_U13-Pad2_ Net-_U23-Pad2_ Net-_U37-Pad1_ d_and
U18 Net-_U28-Pad1_ Net-_U4-Pad2_ Net-_U37-Pad2_ d_and
U47 Net-_U37-Pad3_ Net-_U47-Pad2_ d_inverter
U37 Net-_U37-Pad1_ Net-_U37-Pad2_ Net-_U37-Pad3_ d_and
U39 Net-_U21-Pad3_ Net-_U22-Pad3_ Net-_U39-Pad3_ d_and
U38 Net-_U38-Pad1_ Net-_U38-Pad2_ Net-_U38-Pad3_ d_and
U49 Net-_U39-Pad3_ Net-_U49-Pad2_ d_inverter
U48 Net-_U38-Pad3_ Net-_U48-Pad2_ d_inverter
U50 Net-_U40-Pad3_ Net-_U60-Pad1_ d_inverter
U40 Net-_U40-Pad1_ Net-_U24-Pad3_ Net-_U40-Pad3_ d_and
U51 Net-_U41-Pad3_ Net-_U51-Pad2_ d_inverter
U41 Net-_U25-Pad3_ Net-_U41-Pad2_ Net-_U41-Pad3_ d_and
U69 3 plot_v1
U60 Net-_U60-Pad1_ 4 dac_bridge_1
U59 Net-_U49-Pad2_ 3 dac_bridge_1
U67 1 plot_v1
U57 Net-_U47-Pad2_ 1 dac_bridge_1
U58 Net-_U48-Pad2_ 2 dac_bridge_1
U68 2 plot_v1
U70 4 plot_v1
U71 5 plot_v1
U61 Net-_U51-Pad2_ 5 dac_bridge_1
.end
